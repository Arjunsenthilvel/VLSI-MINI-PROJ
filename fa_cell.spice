.subckt fa a b cin sum cout vdd gnd
XMN1 nco a  n1  gnd sky130_fd_pr__nfet_01v8 W=0.65u L=0.15u
XMN2 n1  b  gnd gnd sky130_fd_pr__nfet_01v8 W=0.65u L=0.15u
XMN3 nco cin n2 gnd sky130_fd_pr__nfet_01v8 W=0.65u L=0.15u
XMN4 n2  a  gnd gnd sky130_fd_pr__nfet_01v8 W=0.65u L=0.15u
XMN5 n2  b  gnd gnd sky130_fd_pr__nfet_01v8 W=0.65u L=0.15u
XMP1 nco a  p1  vdd sky130_fd_pr__pfet_01v8 W=1.3u L=0.15u
XMP2 p1  b  vdd vdd sky130_fd_pr__pfet_01v8 W=1.3u L=0.15u
XMP3 nco cin p2 vdd sky130_fd_pr__pfet_01v8 W=1.3u L=0.15u
XMP4 p2  a  vdd vdd sky130_fd_pr__pfet_01v8 W=1.3u L=0.15u
XMP5 p2  b  vdd vdd sky130_fd_pr__pfet_01v8 W=1.3u L=0.15u
XMN6  ns a   m1 gnd sky130_fd_pr__nfet_01v8 W=0.65u L=0.15u
XMN7  m1 b   m2 gnd sky130_fd_pr__nfet_01v8 W=0.65u L=0.15u
XMN8  m2 cin gnd gnd sky130_fd_pr__nfet_01v8 W=0.65u L=0.15u
XMN9  ns nco m3 gnd sky130_fd_pr__nfet_01v8 W=0.65u L=0.15u
XMN10 m3 a   gnd gnd sky130_fd_pr__nfet_01v8 W=0.65u L=0.15u
XMN11 m3 b   gnd gnd sky130_fd_pr__nfet_01v8 W=0.65u L=0.15u
XMN12 m3 cin gnd gnd sky130_fd_pr__nfet_01v8 W=0.65u L=0.15u
XMP6  ns a   q1 vdd sky130_fd_pr__pfet_01v8 W=1.3u L=0.15u
XMP7  q1 b   q2 vdd sky130_fd_pr__pfet_01v8 W=1.3u L=0.15u
XMP8  q2 cin vdd vdd sky130_fd_pr__pfet_01v8 W=1.3u L=0.15u
XMP9  ns nco q3 vdd sky130_fd_pr__pfet_01v8 W=1.3u L=0.15u
XMP10 q3 a   vdd vdd sky130_fd_pr__pfet_01v8 W=1.3u L=0.15u
XMP11 q3 b   vdd vdd sky130_fd_pr__pfet_01v8 W=1.3u L=0.15u
XMP12 q3 cin vdd vdd sky130_fd_pr__pfet_01v8 W=1.3u L=0.15u
XMN13 cout nco gnd gnd sky130_fd_pr__nfet_01v8 W=0.65u L=0.15u
XMP13 cout nco vdd vdd sky130_fd_pr__pfet_01v8 W=1.3u L=0.15u
XMN14 sum ns gnd gnd sky130_fd_pr__nfet_01v8 W=0.65u L=0.15u
XMP14 sum ns vdd vdd sky130_fd_pr__pfet_01v8 W=1.3u L=0.15u
.ends
